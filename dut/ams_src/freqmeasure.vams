module freqmeasure(e1, gnd, freq, clk, maxv, rdywr, vctrl, vcswr);
	real rdyr, rdya;
	electrical e1, gnd, vctrl, rep, to;
	ground gnd;
	logic clk;
	input e1, gnd, clk, vctrl;

	wreal freq, maxv, rdywr, vcswr;
	output freq, maxv, rdywr, vcswr;

	real t, s, a, f, o, m, b, mi, te, vcs;
	real q[9:0], qm[9:0];

	integer loi;

integer i, k, j, k2, rdy2, rdyi, ti=0;

	analog begin

		V(to) <+ transition(vcs, 0, 990p);

		@(initial_step) begin
			t=0;
			s=0;
			i=0;
			k=0;
			k2=0;
			rdyi=0;
			j=0;
			rdy2=0;
			a=0;
			b=0;
			f=0;rdya=0;
			mi=0;loi=0;
		end

		@(cross(ddt(V(e1, gnd)), +1)) begin
			s = $abstime - t;
			t = $abstime;
			i=i+1;
			if(i>9) begin
				i=0;
				rdyi=1;
			end
			q[i] = s;
			if(rdyi) begin
				for(k=0;k<10;k=k+1) a = a + q[k];
				f = 10/a;
				a = 0;
			end
		end

		@(cross(ddt(V(e1, gnd)), 0)) begin
			j=j+1;
			if(j>9) begin
				j=0;
				rdy2=1;
			end
			qm[j] = abs(V(e1, gnd));
			if(rdy2) begin
				for(k2=0;k2<10;k2=k2+1) b = b + qm[k2];
				mi = b/10;
				b = 0;
			end
		end

		@(timer(7n)) loi=1;

	end

	//always @(absdelta(f,10)) begin

	real lastvc, vctr, outrdy;
	initial begin
		lastvc = 0;
		vctr = 0;
		outrdy = 0;
	end

	always #1 begin
		o = f;
		m = mi;
		vcs = V(vctrl, gnd);

		//$display("freq s: %e, mag : %e, vramp: %e", freq, maxv, vcswr);
		if(abs(V(vctrl, gnd) - lastvc) < 0.0002) begin
			//$display("v+");
			vctr = vctr + 1;
			if(vctr > 9) begin
				outrdy = 1;
				vctr = 0;
			end
		end
		else begin
			//$display("reset");
			vctr = 0;
		end
		lastvc = V(vctrl, gnd);
	end

	always @(absdelta(freq,10)) begin
		te=freq;
	end

	assign freq = o;
	assign maxv = m;
	assign rdywr = rdyr;
	assign vcswr = outrdy;

endmodule
