`include "disciplines.vams"

module varactor(p, n);
    inout p, n;
    electrical p, n;
    parameter real c0 = 2000f from (0:inf);	// nominal capacitance (F)
    parameter real c1 = 1950f from [0:c0);	// maximum capacitance change from nominal (F)
    parameter real v0 = 0;			// voltage for nominal capacitance (V)
    parameter real v1 = 3 from (0:inf);		// voltage change for maximum capacitance (V)
    real q, v;

    analog begin
	v = V(p,n);
	q = c0*v + c1*v1*ln(cosh((v - v0)/v1));
	I(p, n) <+ ddt(q);
    end
endmodule
