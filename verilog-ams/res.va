module res (a, b);
electrical a, b;
parameter real R = 1.0;
analog begin
V(a,b) <+R * I(a,b);
end
endmodule
